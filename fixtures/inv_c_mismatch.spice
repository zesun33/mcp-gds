* res inv with an extra device — LVS mismatch fixture
.subckt inv in out vdd vss
M1 out in vdd vdd pmos w=1u l=0.13u
M2 out in vss vss nmos w=0.5u l=0.13u
M3 out in vss vss nmos w=0.5u l=0.13u
.ends
.end
